Foreign diode: a model card in another house's spelling
v1 supply 0 dc 5
r1 supply anode 470
d1 anode 0 RedLed
.MODEL RedLed d ( n=1.8 rs=2 is=1.016451e-20 )
.op
.end
