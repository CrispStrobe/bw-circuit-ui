Foreign suffixes: every scale letter, plus units that must be ignored
V1 1 0 DC 12
R1 1 2 4.7kOhm
R2 2 3 470
R3 3 4 2.2e3
R4 4 5 100000m
R5 5 0 1k
C1 2 0 100nF
C2 3 0 4.7uF
L1 4 6 10mH
R6 6 0 1G
.op
.end
