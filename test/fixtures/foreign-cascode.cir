* Self-authored foreign-deck fixture: NMOS cascode, LEVEL=1
VDD VDD 0 DC 12
VIN IN 0 AC 1m DC 1.8
VBIAS BIAS 0 DC 6.6
RD VDD OUT 910
M1 CASC IN 0 0 NMOS W=20u L=1u
M2 OUT BIAS CASC 0 NMOS W=20u L=1u
.MODEL NMOS NMOS (LEVEL=1 VTO=1 KP=1.0e-4 LAMBDA=0.005)
.OP
.AC DEC 50 1 1Meg
.END
